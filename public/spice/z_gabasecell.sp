* z_gabasecell.sp — GA base cell and derived standard-cell wrappers

.SUBCKT Z__GABASECELL G1 G2 N1 N2 N3 P1 P2 P3 VDD VSS
MP1 P3 G1 P2 VDD PMOSMOD1 L=0.18u W=87.68u M=1
MP2 P1 G2 P2 VDD PMOSMOD1 L=0.18u W=87.68u M=1
MN1 N3 G1 N2 VSS NMOSMOD1 L=0.18u W=64u    M=1
MN2 N1 G2 N2 VSS NMOSMOD1 L=0.18u W=64u    M=1
C1 N1 0 100f
C2 N2 0 100f
C3 P1 0 100f
C4 P2 0 100f
.ENDS

* INV: both gates tied to IN, drains shorted to OUT
.SUBCKT INV IN OUT VDD VSS
X_BC IN IN OUT VSS OUT OUT VDD OUT VDD VSS Z__GABASECELL
.ENDS

* NOR2: single Z__GABASECELL (pinMap in primitives.json)
.SUBCKT NOR2 A B OUT VDD VSS
X_BC A B OUT VSS OUT OUT _NOR2_PMID VDD VDD VSS Z__GABASECELL
.ENDS

* NAND2: single Z__GABASECELL (pinMap in primitives.json)
.SUBCKT NAND2 A B OUT VDD VSS
X_BC A B OUT _NAND2_NMID VSS OUT VDD OUT VDD VSS Z__GABASECELL
.ENDS

* Single NMOS (same geometry as MN1/MN2 in base cell)
.SUBCKT NMOS D G S VSS
MN1 D G S VSS NMOSMOD1 L=0.18u W=64u M=1
.ENDS

* Single PMOS (same geometry as MP1/MP2 in base cell)
.SUBCKT PMOS D G S VDD
MP1 D G S VDD PMOSMOD1 L=0.18u W=87.68u M=1
.ENDS

* MOS cap: gate-connected NMOS (D=S=PLUS, G=MINUS)
.SUBCKT MOSCAP PLUS MINUS VSS
MN1 PLUS MINUS MINUS VSS NMOSMOD1 L=0.18u W=64u M=1
C1 PLUS MINUS 100f
.ENDS

.model NMOSMOD1 NMOS (LEVEL=1 VTO=0.5 KP=120u LAMBDA=0.02 GAMMA=0.4 PHI=0.6)
.model PMOSMOD1 PMOS (LEVEL=1 VTO=-0.5 KP=40u LAMBDA=0.02 GAMMA=0.4 PHI=0.6)

.end
